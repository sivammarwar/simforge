* Common-Emitter BJT Amplifier
* Generated by SimForge (AI netlist -> SPICE)
Vcc 3 0 dc 12
Rb1 1 0 20k
Rb2 1 2 5k
Q1 3 2 0
Re 0 4 1k
Rc 3 5 5.1k
.control
set filetype=ascii
op
print v(2)
print v(0)
print v(5)
write simforge_out.raw
quit
.endc
.end
