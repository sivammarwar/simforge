* RC Low-Pass Filter
* Generated by SimForge (AI netlist -> SPICE)
V1 1 0 dc 0 AC 1
R1 1 2 1.59k
C1 2 0 100n
.control
set filetype=ascii
ac dec 20 10 1Meg
set wr_singlescale
set wr_vecnames
wrdata simforge_out.txt vdb(2) vp(2)
quit
.endc
.end
