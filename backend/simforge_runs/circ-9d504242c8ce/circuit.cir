* Series RLC Circuit
* Generated by SimForge (AI netlist -> SPICE)
V1 1 0 dc 5
R1 1 2 100
L1 2 3 10m
C1 3 0 1u
.control
set filetype=ascii
tran 1u 10m 0
set wr_singlescale
set wr_vecnames
wrdata simforge_out.txt v(2) v(3)
quit
.endc
.end
