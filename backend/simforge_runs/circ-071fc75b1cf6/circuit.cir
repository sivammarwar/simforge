* RC Low-Pass Filter
* Generated by SimForge (AI netlist -> SPICE)
V1 1 0 ac 1
R1 1 2 1k
C1 2 0 31.83n
.control
set filetype=ascii
ac dec 100 1 100k
set wr_singlescale
set wr_vecnames
wrdata simforge_out.txt vdb(2) vp(2)
quit
.endc
.end
