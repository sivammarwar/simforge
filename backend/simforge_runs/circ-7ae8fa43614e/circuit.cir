* Thermistor Linearization Circuit
* Generated by SimForge (AI netlist -> SPICE)
V1 1 0 dc 5
R10 1 2 1k
R12 2 0 1k
Vref 3 0 dc 2.5
D1 2 0
Rth 2 0 1k
.control
set filetype=ascii
op
print v(4)
write simforge_out.raw
quit
.endc
.end
