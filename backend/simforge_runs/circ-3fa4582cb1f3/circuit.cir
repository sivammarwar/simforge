* Simple Voltage Source
* Generated by SimForge (AI netlist -> SPICE)
V1 0 0 dc 12
.control
set filetype=ascii
op
print v(1)
write simforge_out.raw
quit
.endc
.end
