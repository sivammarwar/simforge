* Resistive Voltage Divider
* Generated by SimForge (AI netlist -> SPICE)
V1 1 0 12
R1 1 2 2k
R2 2 0 3k
.control
set filetype=ascii
op
print v(2)
write simforge_out.raw
quit
.endc
.end
