* Active High-Pass Filter
* Generated by SimForge (AI netlist -> SPICE)
V1 1 0 sin(0 1 5k)
R1 1 2 10k
R2 2 0 10k
R3 2 3 10k
R4 3 0 20k
C1 3 0 10n
.control
set filetype=ascii
tran 1u 1m 0
set wr_singlescale
set wr_vecnames
wrdata simforge_out.txt v(4)
quit
.endc
.end
