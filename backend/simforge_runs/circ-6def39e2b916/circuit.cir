* Common-Emitter BJT Amplifier
* Generated by SimForge (AI netlist -> SPICE)
Vcc 3 0 dc 12
Rb1 1 0 20k
Rb2 1 1 5k
Q1 1 3 0 NPN
Re 0 4 1k
Rc 3 4 5.1k
.control
set filetype=ascii
op
print v(2)
print v(3)
print v(4)
write simforge_out.raw
quit
.endc
.end
