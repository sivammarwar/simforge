* RC Circuit
* Generated by SimForge (AI netlist -> SPICE)
V1 1 0 dc 5
R1 1 2 1k
C1 2 0 1u
.control
set filetype=ascii
tran 1u 10m 0
set wr_singlescale
set wr_vecnames
wrdata simforge_out.txt v(2)
quit
.endc
.end
