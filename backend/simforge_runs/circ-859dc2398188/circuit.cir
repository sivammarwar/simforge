* Common-Emitter BJT Amplifier
* Generated by SimForge (AI netlist -> SPICE)
Vcc 1 0 dc 12
Rc 1 2 5.1k
Q1 2 3 0
Rb 1 3 20k
Re 0 0 1k
.control
set filetype=ascii
op
print v(2)
print v(3)
write simforge_out.raw
quit
.endc
.end
