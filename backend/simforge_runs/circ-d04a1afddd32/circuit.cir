* Simple Resistor Circuit
* Generated by SimForge (AI netlist -> SPICE)
V1 1 0 5
R1 1 0 1k
.control
set filetype=ascii
op
print v(1)
write simforge_out.raw
quit
.endc
.end
