* BJT Characteristic Curves
* Generated by SimForge (AI netlist -> SPICE)
Vce 1 0 dc 0
Ib 2 0 dc
Q1 1 2 0 NPN
.control
set filetype=ascii
op
print v(1)
write simforge_out.raw
quit
.endc
.end
