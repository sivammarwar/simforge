* RC Low-Pass Filter
V1 1 0 DC 0 AC 1
R1 1 2 1k
C1 2 0 1e-6
.ac dec 100 10 100000
.control
  set filetype=ascii
  run
  write rc_lowpass.raw
  quit
.endc
.end
