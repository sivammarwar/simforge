* Voltage Divider
* Generated by SimForge

Vin 1 0 DC 12.0
R1 1 2 1000.0
R2 2 0 1000.0

.TRAN 1u 10m
.control
run
write circuit.raw
quit
.endc
.END
