* Second-order system step response
V1 1 0 PULSE(0 1 0 1n 1n 0 1)
R1 1 2 5
L1 2 3 1
C1 3 0 0.04
.tran 0.001 5
.control
  set filetype=ascii
  run
  write step_response.raw
  quit
.endc
.end
