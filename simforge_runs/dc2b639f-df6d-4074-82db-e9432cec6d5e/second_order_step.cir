* Second-order system step response (ω_n=5 rad/s, ζ=0.5)
V1 1 0 PULSE(0 1 0 1n 1n 1 2)
R1 1 2 0.2
L1 2 3 0.04
C1 3 0 1
.tran 0.001 5
.control
  set filetype=ascii
  run
  write step_response.raw
  quit
.endc
.end
