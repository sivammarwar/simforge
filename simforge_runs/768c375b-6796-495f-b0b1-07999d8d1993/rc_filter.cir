R1 1 2 1k
C1 2 0 1e-6
V1 1 0 DC 0 AC 1
.ac dec 100 10 100k
.control
  run
  plot v(2)
.endc
