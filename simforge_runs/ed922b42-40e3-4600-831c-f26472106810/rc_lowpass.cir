* RC Low-Pass Filter
V1 1 0 DC 0 AC 1
R1 1 2 1k
C1 2 0 232 F
.ac dec 100 10 100k
.control
  set filetype=ascii
  run
  write rc_lowpass.raw
  quit
.endc
.end
